simulator lang=spectre
include "ade_e.scs"
parameters temperature=27 FN=4 WN=0.9u FP=5 WP=0.7u
tran tran stop=10n
dc dc
